//////////////////////////////////////////////////

library par_rc
//////////////////////////////////////////////////
section typi_typi
//////////////////////////////////////////////////
 simulator lang = spectre
include "trtc.cor"
endsection typi_typi
//////////////////////////////////////////////////

//////////////////////////////////////////////////
section low_low
//////////////////////////////////////////////////
 simulator lang = spectre
include "lrlc.cor"
endsection low_low
//////////////////////////////////////////////////

//////////////////////////////////////////////////
section high_high
//////////////////////////////////////////////////
 simulator lang = spectre
include "hrhc.cor"
endsection high_high
//////////////////////////////////////////////////

//////////////////////////////////////////////////
section low_high
//////////////////////////////////////////////////
 simulator lang = spectre
include "lrhc.cor"
endsection low_high
//////////////////////////////////////////////////

//////////////////////////////////////////////////
section high_low
//////////////////////////////////////////////////
 simulator lang = spectre
include "hrlc.cor"
endsection high_low
//////////////////////////////////////////////////

endlibrary par_rc
