// Design: avatar_local/fet_test
simulator lang=spectre
global 0
parameters rwaferback=rwaferback_tbd subthick=subthick_tbd vwaferback=vwaferback_tbd
include "/cad/kits/harvard/xfab_top/XKIT/xr013/cadence/v3_2/spectre/v3_2_1/core/config.scs" section=default
include "/cad/kits/harvard/xfab_top/XKIT/xr013/cadence/v3_2/spectre/v3_2_1/core/param.scs" section=3s
include "/cad/kits/harvard/xfab_top/XKIT/xr013/cadence/v3_2/spectre/v3_2_1/core/cap.scs" section=tm
include "/cad/kits/harvard/xfab_top/XKIT/xr013/cadence/v3_2/spectre/v3_2_1/core/dio.scs" section=tm
include "/cad/kits/harvard/xfab_top/XKIT/xr013/cadence/v3_2/spectre/v3_2_1/core/ind.scs" section=tm
include "/cad/kits/harvard/xfab_top/XKIT/xr013/cadence/v3_2/spectre/v3_2_1/core/mos.scs" section=tm
include "/cad/kits/harvard/xfab_top/XKIT/xr013/cadence/v3_2/spectre/v3_2_1/core/res.scs" section=tm

//include "$CS148/rram_model/Models/rram0.scs" section=rram
include "../Models/rram0.scs" section=rram

// avatar_local/fet_test/schematic
//N0 (net1 net_vg 0 0) nmos2vbc_4 l=320.0n wfinger=4u nfinger=1 m=1 sa=360n sb=360n sd=0
//N0 (net1 net_vg net_vs net_vs) nmos2vbc_4 l=320.0n wfinger=4u nfinger=1 m=1 sa=360n sb=360n sd=0
//N0 (net1 net_vg net_vs 0) nmos2vbc_4 l=320.0n wfinger=4u nfinger=1 m=1 sa=360n sb=360n sd=0
N0 (net1 net_vg net_vs 0) nmos2vbc_4 l=320.0n wfinger=10u nfinger=10 m=1 sa=360n sb=360n sd=0

//I0 (net1 net_vd) rpoly1h_2t value=10.24K w=400n ser=1 m=1
//I0 (net_vd net1) rram0 gap_max=2.0e-9

//I0 (net_vd net1) rram0 Vel0=150
I0 (net_vd net1) rram0 gap_ini=0.1e-9

//VG (net_vg 0) vsource type=pwl wave=[ 0 1.5 400n 1.5 450n 2 1u 2 ]
//VD (net_vd 0) vsource type=pwl wave=[ 0 0 200n 2.5 600n -2.5 800n 0 1u 0 ]

//VG (net_vg 0) vsource type=pwl wave=[ 0 1.5 400n 1.5 401n 2 ]
//VD (net_vd 0) vsource type=pwl wave=[ 0 0 200n 2.5 400n 0 401n -0.5 ]

//VG (net_vg 0) vsource type=pwl wave=[ 0 1.5 400p 1.5 401p 2 ]
//VD (net_vd 0) vsource type=pwl wave=[ 0 0 200p 2.5 400p 0 401p -0.5 ]

VG (net_vg 0) vsource type=pwl wave=[ 0 1.5 400n 1.5 ]
//VG (net_vg 0) vsource type=pwl wave=[ 0 2.5 400n 2.5 ]
//VD (net_vd 0) vsource type=pwl wave=[ 0 0 200n 2.5 400n 0 ]
VD (net_vd 0) vsource type=pwl wave=[ 0 0 200n 1.5 400n 0 ]
VS (net_vs 0) vsource type=pwl wave=[ 0 0 400n 0 401n 1.5 ]

//VG (net_vg 0) vsource type=pwl wave=[ 0 2 ]
//VD (net_vd 0) vsource type=pwl wave=[ 0 -2.5 ]

//VG (net_vg 0) vsource type=pwl wave=[ 0 1.5 400n 1.5 450n 2 1u 2 2u 2 ]
//VD (net_vd 0) vsource type=pwl wave=[ 0 0 200n 2.5 600n -2.5 1600n -2.5 ]

simulatorOptions options temp=27

tran tran stop=10u
save VD:p
